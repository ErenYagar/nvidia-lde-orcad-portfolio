* Stage 3 recovery sweep: COUT=132uF ESR=5mOhm CFF=8.2pF
* Official TI SLUM787A TPS543620 encrypted transient macro-model.
.LIB "C:/project/orcad_project/nvidia-lde-orcad-portfolio/pspice/vendor_models/ti/SLUM787A/TPS543620_PSPICE_TRANS/TPS543620_PSPICE_TRANS/tps543620_trans.lib"

XU2 FSEL 0 FB VIN EN PGOOD MODE BP5 SW SW BOOT 0 0 VIN TPS543620RPY_TRANS
RFSEL FSEL 0 8.06K
RMODE MODE 0 11.3K
CBP5 BP5 0 2.2U
RPGOOD BP5 PGOOD 10K
CBOOT BOOT SW 100N
CIN_BULK VIN 0 20U
CIN_HF VIN 0 200N
L1 SW LX 1.5U
RL1_DCR LX P3V3_PRE 5M
RESR_COUT P3V3_PRE COUT_INT 5M
COUT COUT_INT 0 132U
RFB_TOP P3V3_PRE FB 56K
RFB_BOT FB 0 10K
CFF P3V3_PRE FB 8.2P
RSHUNT P3V3_PRE P3V3_NVME 5M

VINPUT VIN 0 12
VEN EN 0 PWL(0 0 20U 0 25U 3.3)
ILOAD P3V3_NVME 0 PWL(
+ 0 0
+ 650U 0
+ 655U 0.5
+ 1100U 0.5
+ 1105U 5
+ 1200U 5
+ 1205U 7
+ 1305U 7
+ 1310U 5
+ 1360U 5
+ 1365U 0.5
+ 1400U 0.5
+)

.TRAN 2U 1.4M 0 200N
.OPTIONS ABSTOL=10P ITL2=50 ITL4=20 METHOD=GEAR TRTOL=500
.PROBE/CSDF V(*) I(*)
.END
